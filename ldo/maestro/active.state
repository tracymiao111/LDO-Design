ADE simulation setup
Test ece483_sp23_ea_1: ece483_sp23/ldo/schematic, simulator spectre
  Models: /class/ece483/models/models_ece483
  Variables: Cout = 200p; Rf1 = 928.57; Rf2 = 1071.43; RL = 70; vin = 0; VIN = 1.8; vref = 0; VREF = 0.75; t_step_VIN = 0; VSTEP = 0; t_step_LD = 0; LDSTEP = 0
  Temperature: 27
  Analysis stb: start=1 stop=10G probe=/VSTAB stbProbeMode=differential
  Analysis noise: start=100 stop=10G p=/Vout n=/vss iprobe=/V2
  Analysis tran: stop=20u errpreset=moderate
  Analysis dc: (saves the operating point)
  Analysis ac: start=1 stop=1G dec=101
  Output LG = db(mag(getData("loopGain" ?result "stb"))) (unticked)
  Output LG0 = value(LG 1)
  Output LG_fUGF = cross(LG 0)
  Output Loop Gain Phase Margin = phaseDegUnwrapped(getData("loopGain" ?result "stb"))
  Output Loop Gain Phase = (phaseDegUnwrapped(getData("loopGain" ?result "stb")) - 180)
  Output Loop Gain dB20 = db(mag(getData("loopGain" ?result "stb")))
  Output Phase Margin = getData("phaseMargin" ?result "stb_margin")
  Output Gain Margin = getData("gainMargin" ?result "stb_margin")
  Output PSR = db(VF("/Vout"))
  Output Vout_EA = VDC("/vout")
  Output Vout = VDC("/Vout")
  Output IL = IDC("/R2/PLUS")
  Output Vout_tran = VT("/Vout")
  Output Vin_tran = VT("/vdd")
  Output IL_tran = IT("/R2/PLUS")
  Output Noise = VN2() (unticked)
  Output Itot = abs(IDC("/V4/PLUS"))
  Output IQ = (abs(IDC("/V4/PLUS")) - abs(IDC("/R2/PLUS")))
  Output ImirrorP = abs(OP("/P0" "ids"))
  Output ImirrorN = abs(OP("/N3" "ids"))
  Output IoutL = abs(OP("/N8" "ids"))
  Output IouttailL_P = abs(OP("/P5" "ids"))
  Output IouttailL_N = abs(OP("/N10" "ids"))
  Output IoutR = abs(OP("/P8" "ids"))
  Output IouttailR_P = abs(OP("/P6" "ids"))
  Output IouttailR_N = abs(OP("/N11" "ids"))
  Output ItailDiff_P = abs(OP("/P11" "ids"))
  Output IdiffL_P = abs(OP("/P9" "ids"))
  Output IdiffR_P = abs(OP("/P10" "ids"))
  Output ItailDiff_N = abs(OP("/N14" "ids"))
  Output IdiffL_N = abs(OP("/N12" "ids"))
  Output IdiffR_N = abs(OP("/N13" "ids"))
  Output Pass_PMOS_Region = OP("/P2" "region")
  Output Pass_PMOS_gm = OP("/P2" "gm")
  Output Pass_PMOS_rds = OP("/P2" "rout")
  Output Pass_PMOS_vov = (abs(OP("/P2" "vgs")) + OP("/P2" "vth"))
  Output Pass_PMOS_vdsat = abs(OP("/P2" "vdsat"))
  Output Mirror_P_Top_Region = OP("/P0" "region")
  Output Mirror_P_Top_vov = (abs(OP("/P0" "vgs")) + OP("/P0" "vth"))
  Output Mirror_P_1/3x_Region = OP("/P3" "region")
  Output Mirror_P_1/3x_vov = (abs(OP("/P3" "vgs")) + OP("/P3" "vth"))
  Output Mirror_P_1x_Region = OP("/P4" "region")
  Output Mirror_P_1x_vov = (abs(OP("/P4" "vgs")) + OP("/P4" "vth"))
  Output vbp1 = VDC("/vbp1")
  Output vbp2 = VDC("/vbp2")
  Output Mirror_N_TopTail_Region = OP("/P1" "region")
  Output Mirror_N_TopTail_vov = (abs(OP("/P1" "vgs")) + OP("/P1" "vth"))
  Output Miror_N_1x_Region = OP("/N0" "region")
  Output Miror_N_1x_vov = (abs(OP("/N0" "vgs")) - OP("/N0" "vth"))
  Output Miror_N_1/3x_Region = OP("/N1" "region")
  Output Miror_N_1/3x_vov = (abs(OP("/N1" "vgs")) - OP("/N1" "vth"))
  Output Miror_N_Sec_Region = OP("/N3" "region")
  Output Miror_N_Sec_vov = (abs(OP("/N3" "vgs")) - OP("/N3" "vth"))
  Output vbn1 = VDC("/vbn1")
  Output vbn2 = VDC("/vbn2")
  Output DiffTailRegion_P = OP("/P11" "region")
  Output DiffTail_gm_P = OP("/P11" "gm")
  Output DiffTail_rds_P = OP("/P11" "rout")
  Output Difftail_vov_P = (abs(OP("/P11" "vgs")) + OP("/P11" "vth"))
  Output Diff_L_Region_P = OP("/P9" "region")
  Output Diff_L_gm_P = OP("/P9" "gm")
  Output Diff_L_rds_P = OP("/P9" "rout")
  Output Diff_L_vov_P = (abs(OP("/P9" "vgs")) + OP("/P9" "vth"))
  Output Diff_R_Region_P = OP("/P10" "region")
  Output Diff_R_gm_P = OP("/P10" "gm")
  Output Diff_R_rds_P = OP("/P10" "rout")
  Output Diff_R_vov_P = (abs(OP("/P10" "vgs")) + OP("/P10" "vth"))
  Output DiffTailRegion_N = OP("/N14" "region")
  Output DiffTail_gm_N = OP("/N14" "gm")
  Output DiffTail_rds_N = OP("/N14" "rout")
  Output Difftail_vov_N = (abs(OP("/N14" "vgs")) - OP("/N14" "vth"))
  Output Diff_L_Region_N = OP("/N12" "region")
  Output Diff_L_gm_N = OP("/N12" "gm")
  Output Diff_L_rds_N = OP("/N12" "rout")
  Output Diff_L_vov_N = (abs(OP("/N12" "vgs")) - OP("/N12" "vth"))
  Output Diff_R_Region_N = OP("/N13" "region")
  Output Diff_R_gm_N = OP("/N13" "gm")
  Output Diff_R_rds_N = OP("/N13" "rout")
  Output Diff_R_vov_N = (abs(OP("/N13" "vgs")) - OP("/N13" "vth"))
  Output L_Bottom_Region = OP("/N10" "region")
  Output L_Bottom_gm = OP("/N10" "gm")
  Output L_Bottom_rds = OP("/N10" "rout")
  Output L_Bottom_vov = (abs(OP("/N10" "vgs")) - OP("/N10" "vth"))
  Output R_Bottom_Region = OP("/N11" "region")
  Output R_Bottom_gm = OP("/N11" "gm")
  Output R_Bottom_rds = OP("/N11" "rout")
  Output R_Bottom_vov = (abs(OP("/N11" "vgs")) - OP("/N11" "vth"))
  Output L_NMOS_Region = OP("/N8" "region")
  Output L_NMOS_gm = OP("/N8" "gm")
  Output L_NMOS_rds = OP("/N8" "rout")
  Output L_NMOS_vov = (abs(OP("/N8" "vgs")) - OP("/N8" "vth"))
  Output R_NMOS_Region = OP("/N9" "region")
  Output R_NMOS_gm = OP("/N9" "gm")
  Output R_NMOS_rds = OP("/N9" "rout")
  Output R_NMOS_vov = (abs(OP("/N9" "vgs")) - OP("/N9" "vth"))
  Output L_CAS_NMOS_Region = OP("/N2" "region")
  Output L_CAS_NMOS_gm = OP("/N2" "gm")
  Output L_CAS_NMOS_rds = OP("/N2" "rout")
  Output L_CAS_NMOS_vov = (abs(OP("/N2" "vgs")) - OP("/N2" "vth"))
  Output R_CAS_NMOS_Region = OP("/N16" "region")
  Output R_CAS_NMOS_gm = OP("/N16" "gm")
  Output R_CAS_NMOS_rds = OP("/N16" "rout")
  Output R_CAS_NMOS_vov = (abs(OP("/N16" "vgs")) - OP("/N16" "vth"))
  Output L_CAS_PMOS_Region = OP("/P13" "region")
  Output L_CAS_PMOS_gm = OP("/P13" "gm")
  Output L_CAS_PMOS_rds = OP("/P13" "rout")
  Output L_CAS_PMOS_vov = (abs(OP("/P13" "vgs")) + OP("/P13" "vth"))
  Output R_CAS_PMOS_Region = OP("/P15" "region")
  Output R_CAS_PMOS_gm = OP("/P15" "gm")
  Output R_CAS_PMOS_rds = OP("/P15" "rout")
  Output R_CAS_PMOS_vov = (abs(OP("/P15" "vgs")) + OP("/P15" "vth"))
  Output L_PMOS_Region = OP("/P7" "region")
  Output L_PMOS_gm = OP("/P7" "gm")
  Output L_PMOS_rds = OP("/P7" "rout")
  Output L_PMOS_vov = (abs(OP("/P7" "vgs")) + OP("/P7" "vth"))
  Output R_PMOS_Region = OP("/P8" "region")
  Output R_PMOS_gm = OP("/P8" "gm")
  Output R_PMOS_rds = OP("/P8" "rout")
  Output R_PMOS_vov = (abs(OP("/P8" "vgs")) + OP("/P8" "vth"))
  Output L_Top_Region = OP("/P5" "region")
  Output L_Top_gm = OP("/P5" "gm")
  Output L_Top_rds = OP("/P5" "rout")
  Output L_Top_vov = (abs(OP("/P5" "vgs")) + OP("/P5" "vth"))
  Output R_Top_Region = OP("/P6" "region")
  Output R_Top_gm = OP("/P6" "gm")
  Output R_Top_rds = OP("/P6" "rout")
  Output R_Top_vov = (abs(OP("/P6" "vgs")) + OP("/P6" "vth"))
  Signals: /V4/PLUS (terminal), /R2/PLUS (terminal)
Run mode: Single Run, Sweeps and Corners
