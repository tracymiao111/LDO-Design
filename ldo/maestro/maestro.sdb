ADE simulation setup
Run mode: Single Run, Sweeps and Corners
Tests:
  ece483_sp23_ea_1: ece483_sp23/ldo/schematic, simulator spectre
    Variables: Cout = 200p; Rf1 = 928.57; Rf2 = 1071.43; RL = 70; vin = 0; VIN = 1.8; vref = 0; VREF = 0.75; t_step_VIN = 0; VSTEP = 0; t_step_LD = 0; LDSTEP = 0
    Outputs: LG; LG0; LG_fUGF; Vout; Itot; ImirrorP; ImirrorN; IoutL; IouttailL_N; IoutR; IouttailR_N; IouttailL_P; IouttailR_P; abs(OP("/P6" "ids")); ItailDiff_P; IdiffL_P; IdiffR_P; ItailDiff_N; IdiffL_N; IdiffR_N; Mirror_P_Top_Region; Mirror_P_Top_vov; Mirror_P_1x_Region; Mirror_P_1x_vov; Mirror_P_1/3x_Region; Mirror_P_1/3x_vov; vbp1; vbp2; Mirror_N_TopTail_Region; Mirror_N_TopTail_vov; Miror_N_1x_Region; Miror_N_1x_vov; Miror_N_1/3x_Region; Miror_N_1/3x_vov; Miror_N_Sec_Region; Miror_N_Sec_vov; vbn1; vbn2; DiffTailRegion_P; DiffTail_gm_P; DiffTail_rds_P; Difftail_vov_P; Diff_L_Region_P; Diff_L_gm_P; Diff_L_rds_P; Diff_L_vov_P; Diff_R_Region_P; Diff_R_gm_P; Diff_R_rds_P; Diff_R_vov_P; DiffTailRegion_N; DiffTail_gm_N; DiffTail_rds_N; Difftail_vov_N; Diff_L_Region_N; Diff_L_gm_N; Diff_L_rds_N; Diff_L_vov_N; Diff_R_Region_N; Diff_R_gm_N; Diff_R_rds_N; Diff_R_vov_N; L_Bottom_Region; L_Bottom_gm; L_Bottom_rds; L_Bottom_vov; R_Bottom_Region; R_Bottom_gm; R_Bottom_rds; R_Bottom_vov; L_NMOS_Region; L_NMOS_gm; L_NMOS_rds; L_NMOS_vov; R_NMOS_Region; R_NMOS_gm; R_NMOS_rds; R_NMOS_vov; L_PMOS_Region; L_PMOS_gm; L_PMOS_rds; L_PMOS_vov; R_PMOS_Region; R_PMOS_gm; R_PMOS_rds; R_PMOS_vov; L_Top_Region; L_Top_gm; L_Top_rds; L_Top_vov; R_Top_Region; R_Top_gm; R_Top_rds; R_Top_vov; Loop Gain Phase Margin; Loop Gain dB20; Phase Margin; Gain Margin; Vout_tran; Vin_tran; IL; IL_tran; L_CAS_NMOS_Region; L_CAS_NMOS_gm; L_CAS_NMOS_rds; L_CAS_NMOS_vov; R_CAS_NMOS_Region; R_CAS_NMOS_gm; R_CAS_NMOS_rds; R_CAS_NMOS_vov; L_CAS_PMOS_Region; L_CAS_PMOS_gm; L_CAS_PMOS_rds; L_CAS_PMOS_vov; R_CAS_PMOS_Region; R_CAS_PMOS_gm; R_CAS_PMOS_rds; R_CAS_PMOS_vov; Pass_PMOS_Region; Pass_PMOS_gm; Pass_PMOS_rds; Pass_PMOS_vov; Pass_PMOS_vdsat; Vout_EA; IQ; PSR; Loop Gain Phase; Noise
